* Reverse battery, FAST 10 us edge (worst case): 13.5 V -> -14 V, 50 mohm source
* SIMULATED in LTspice - generated by run_sims.py
V_SRC src 0 PWL(0 13.5 10m 13.5 10.01m -14 120m -14)
R_RI  src bat 0.05 ; source resistance
* bidirectional TVS (two back-to-back diodes) at the connector
D_T1  bat mid TVS
D_T2  0   mid TVS
* reverse-battery P-FET: drain=bat, source=vin, gate pulled to GND, 15 V zener limits Vgs
M_Q1  bat gate vin vin PFET
R_G   gate 0 10k
D_Z   gate vin ZEN15
* bulk input capacitor and load (5 V/3 A converter at ~1.5 A input, modelled as a resistor)
C_IN  vin 0 10u
R_LD  vin 0 8
.model TVS D(Is=1n Rs=1.47 Bv=36.7 Ibv=1m N=1) ; SMBJ33CA approx: Vbr 36.7 V @1 mA, Rd=(53.3-36.7)/11.3 ohm
.model PFET VDMOS(pchan Vto=-2.5 Kp=7 Rd=3m Rs=2m Rg=3 Cgs=1n Cgdmax=300p Cgdmin=100p Cjo=300p Is=1e-9 Rb=5m)
.model ZEN15 D(Is=1n Bv=15 Ibv=1m Rs=5)
.tran 0 0.12 0 5e-06
.save V(src) V(bat) V(mid) V(vin) V(gate) I(D_T1) I(D_T2) I(R_LD) I(R_RI)
.end
